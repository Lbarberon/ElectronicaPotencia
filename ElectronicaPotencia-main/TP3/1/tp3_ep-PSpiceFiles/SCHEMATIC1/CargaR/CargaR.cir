** Profile: "SCHEMATIC1-CargaR"  [ c:\users\lucho\onedrive\escritorio\electronicapotencia-main\tp3\1\tp3_ep-PSpiceFiles\SCHEMATIC1\CargaR.sim ]

** Creating circuit file "CargaR.cir"
** WARNING: THIS AUTOMATICALLY GENERATED FILE MAY BE OVERWRITTEN BY SUBSEQUENT SIMULATIONS

*Libraries:
* Profile Libraries :
* Local Libraries :
* From [PSPICE NETLIST] section of C:\Users\lucho\cdssetup\OrCAD_PSpice\23.1.0\PSpice.ini file:
.lib "nom.lib"

*Analysis directives:
.TRAN  0 80ms 0 0.01ms
.OPTIONS ADVCONV
.PROBE64 V(alias(*)) I(alias(*)) W(alias(*)) D(alias(*)) NOISE(alias(*))
.INC "..\SCHEMATIC1.net"

.END
